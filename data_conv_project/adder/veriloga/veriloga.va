// VerilogA for data_conv_project, adder, veriloga

`include "constants.vams"
`include "disciplines.vams"

module adder(clk,vdin1,vdin2,vout);

input [5:0] vdin1;
electrical [5:0] vdin1;

input clk;
electrical clk;

parameter tt= 10p;

parameter vth = 0.9;

input [6:0] vdin2;
electrical [6:0] vdin2;

output vout;
electrical vout;

integer j;
real tmp1;
real tmp2;

parameter vdd = 1.8;

real sum;

analog begin

	tmp1 = 0;
	tmp2 = 0;

	generate j(0,5) begin
	tmp2 = 2*tmp2 + (V(vdin2[5-j]))/vdd;
	end

	generate j(0,5) begin
	tmp1 = 2*tmp1 + (V(vdin1[5-j]))/vdd;
	end

	V(vout) <+ ((((tmp1*64)+(tmp2))/4095)*1.8);

end

endmodule
